V1 3 0 DC 0
R1 3 2 1k
C1 2 0 1u
L1 2 0 1m
.END
