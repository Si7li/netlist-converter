VCC 3 0 DC 15V
Vin 1 0 AC 1V
R1 3 2 1k
Q1 2 1 4 N40004
Q2 3 2 4 N40004
.model N40004 NPN(IS=1E-14 BF=100)
.end
