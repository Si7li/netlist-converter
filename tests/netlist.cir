* NMOS Transistor Circuit
VDD 2 0 DC 5V
RD 2 3 1k
M1 3 Vin 0 0 NMOS_MODEL
* Define the model parameters for NMOS
.model NMOS_MODEL NMOS (LEVEL=1 VTO=0.7 KP=120u W=1u L=1u)

* Input Voltage Source
Vin Vin 0 DC 0V

* Analysis
.TRAN 1n 100n
.END
