V1 1 0 DC 12V
V2 3 0 DC 12V
V3 5 0 DC 12V
M1 2 1 4 4 NMOS
M2 2 3 4 4 NMOS
M3 2 5 4 4 NMOS
R1 2 4 1k
.END
